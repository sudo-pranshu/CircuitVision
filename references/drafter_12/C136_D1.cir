* C136_D1
* drafted by Claude from C136_D1_P1.jpg, 2026-11-04; checked against the photo by Pawan Shinde, 2026-11-04
* no values written on the drawing: defaults used
* omitted: switch between nodes 1 and 2
V1 1 0 DC 5
R1 2 0 1k
.op
.end
