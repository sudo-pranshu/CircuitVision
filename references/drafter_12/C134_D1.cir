* C134_D1
* drafted by Claude from C134_D1_P1.jpg, 2026-11-04; checked against the photo by Pawan Shinde, 2026-11-04
* no values written on the drawing: defaults used
* omitted: AC source between nodes 1 (+) and 0
R1 1 2 1k
C1 2 3 1u
L1 3 0 1m
.op
.end
