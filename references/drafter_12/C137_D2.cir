* C137_D2
* drafted by Claude from C137_D2_P1.jpg, 2026-11-04; checked against the photo by Pawan Shinde, 2026-11-04
* no values written on the drawing: defaults used
V1 1 0 DC 5
R1 1 2 1k
C1 2 3 1u
R2 3 0 1k
R3 3 0 1k
.op
.end
