* C138_D2
* drafted by Claude from C138_D2_P1.jpg, 2026-11-04; checked against the photo by Pawan Shinde, 2026-11-04
* no values written on the drawing: defaults used; battery drawn with - on top, so node 0 is the diode's anode side
* omitted: switch between nodes 2 and 1
V1 1 0 DC 5
D1 0 2 DMOD
L1 2 3 1m
C1 1 3 1u
R1 3 1 1k
.model DMOD D
.op
.end
