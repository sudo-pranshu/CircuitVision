* drafter_12/C139_D2_P2.jpg
* ground: none
.op
.end
