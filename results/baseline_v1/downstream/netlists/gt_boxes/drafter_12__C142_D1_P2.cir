* drafter_12/C142_D1_P2.jpg
* ground: none
.op
.end
