* drafter_12/C141_D1_P4.jpg
* ground: none
.op
.end
