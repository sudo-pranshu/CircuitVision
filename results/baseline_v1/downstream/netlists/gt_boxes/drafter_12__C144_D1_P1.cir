* drafter_12/C144_D1_P1.jpg
* ground: none
.op
.end
