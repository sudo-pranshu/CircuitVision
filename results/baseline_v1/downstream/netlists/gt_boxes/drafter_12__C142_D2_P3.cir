* drafter_12/C142_D2_P3.jpg
* ground: none
.op
.end
