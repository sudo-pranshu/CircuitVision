* drafter_12/C135_D1_P4.jpg
* ground: implicit: most connected net
D1 0 4 DMOD
D2 1 2 DMOD
D3 0 1 DMOD
D4 4 2 DMOD
.model DMOD D
.op
.end
