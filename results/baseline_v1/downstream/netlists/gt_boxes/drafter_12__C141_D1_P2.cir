* drafter_12/C141_D1_P2.jpg
* ground: none
.op
.end
