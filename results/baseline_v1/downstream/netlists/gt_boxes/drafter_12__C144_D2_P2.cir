* drafter_12/C144_D2_P2.jpg
* ground: none
.op
.end
