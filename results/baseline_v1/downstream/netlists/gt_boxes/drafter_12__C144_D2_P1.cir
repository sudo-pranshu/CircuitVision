* drafter_12/C144_D2_P1.jpg
* ground: none
.op
.end
