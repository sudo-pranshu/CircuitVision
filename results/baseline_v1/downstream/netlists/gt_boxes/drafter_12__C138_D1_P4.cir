* drafter_12/C138_D1_P4.jpg
* ground: implicit: first source, second terminal
R1 3 5 1k
C1 3 5 1u
D1 0 2 DMOD
V1 4 0 DC 5
L1 2 3 1m
.model DMOD D
.op
.end
