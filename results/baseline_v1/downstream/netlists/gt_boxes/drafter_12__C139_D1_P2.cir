* drafter_12/C139_D1_P2.jpg
* ground: none
.op
.end
