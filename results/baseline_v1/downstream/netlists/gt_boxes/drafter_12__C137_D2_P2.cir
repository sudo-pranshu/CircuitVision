* drafter_12/C137_D2_P2.jpg
* ground: implicit: most connected net
R2 9 13 2
C1 0 9 1u
* WARNING R1: found 1 terminals [0], skipped
* WARNING R3: found 0 terminals [], skipped
* WARNING V1: found 0 terminals [], skipped
.op
.end
