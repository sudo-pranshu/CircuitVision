* drafter_12/C142_D1_P4.jpg
* ground: none
.op
.end
