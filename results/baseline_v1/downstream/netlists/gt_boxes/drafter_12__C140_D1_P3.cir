* drafter_12/C140_D1_P3.jpg
* ground: none
.op
.end
