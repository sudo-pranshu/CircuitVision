* drafter_12/C143_D2_P3.jpg
* ground: none
.op
.end
