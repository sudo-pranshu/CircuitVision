* drafter_12/C143_D1_P1.jpg
* ground: none
.op
.end
