* drafter_12/C143_D1_P3.jpg
* ground: none
.op
.end
