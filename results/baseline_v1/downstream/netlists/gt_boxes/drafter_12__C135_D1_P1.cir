* drafter_12/C135_D1_P1.jpg
* ground: none
* WARNING D1: found 0 terminals [], skipped
* WARNING D2: found 0 terminals [], skipped
* WARNING D3: found 0 terminals [], skipped
* WARNING D4: found 0 terminals [], skipped
.op
.end
