* drafter_12/C140_D2_P4.jpg
* ground: none
.op
.end
