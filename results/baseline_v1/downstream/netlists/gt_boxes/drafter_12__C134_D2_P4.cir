* drafter_12/C134_D2_P4.jpg
* ground: implicit: most connected net
R1 1 0 1k
L1 3 4 1m
C1 0 4 1u
.op
.end
