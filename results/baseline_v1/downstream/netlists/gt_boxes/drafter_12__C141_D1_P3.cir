* drafter_12/C141_D1_P3.jpg
* ground: none
.op
.end
