* drafter_12/C133_D1_P3.jpg
* ground: implicit: first source, second terminal
R1 5 6 1k
V1 5 0 DC 5
L1 1 6 1m
* WARNING C1: found 1 terminals [5], skipped
.op
.end
