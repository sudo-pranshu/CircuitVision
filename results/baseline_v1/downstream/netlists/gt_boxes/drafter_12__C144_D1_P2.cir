* drafter_12/C144_D1_P2.jpg
* ground: none
.op
.end
