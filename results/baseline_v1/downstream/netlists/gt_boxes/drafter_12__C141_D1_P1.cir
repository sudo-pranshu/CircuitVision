* drafter_12/C141_D1_P1.jpg
* ground: none
.op
.end
