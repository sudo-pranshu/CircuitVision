* drafter_12/C143_D1_P2.jpg
* ground: none
.op
.end
