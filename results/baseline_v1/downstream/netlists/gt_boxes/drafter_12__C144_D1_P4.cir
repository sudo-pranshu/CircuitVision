* drafter_12/C144_D1_P4.jpg
* ground: none
.op
.end
