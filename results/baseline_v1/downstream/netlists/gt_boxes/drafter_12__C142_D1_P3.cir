* drafter_12/C142_D1_P3.jpg
* ground: none
.op
.end
