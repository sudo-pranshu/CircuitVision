* drafter_12/C137_D1_P1.jpg
* ground: implicit: first source, second terminal
C1 3 2 1u
R1 2 0 1k
R2 1 3 1k
R3 2 0 1k
V1 1 0 DC 5
.op
.end
