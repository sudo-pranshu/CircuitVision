* drafter_12/C139_D1_P4.jpg
* ground: none
.op
.end
