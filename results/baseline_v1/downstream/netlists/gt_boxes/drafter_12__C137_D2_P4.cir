* drafter_12/C137_D2_P4.jpg
* ground: implicit: most connected net
C1 3 0 1u
R1 0 5 2
R2 2 3 1k
R3 0 5 1k
* WARNING V1: found 4 terminals [2, 4, 5, 6], skipped
.op
.end
