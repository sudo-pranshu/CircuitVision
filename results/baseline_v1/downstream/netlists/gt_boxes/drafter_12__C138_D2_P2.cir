* drafter_12/C138_D2_P2.jpg
* ground: implicit: first source, second terminal
R1 3 4 1k
L1 2 3 1m
C1 3 4 1u
V1 4 0 DC 5
D1 0 2 DMOD
.model DMOD D
.op
.end
