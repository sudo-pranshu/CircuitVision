* drafter_12/C144_D2_P4.jpg
* ground: none
.op
.end
