* drafter_12/C134_D2_P3.jpg
* ground: implicit: most connected net
R1 2 0 1k
L1 3 4 1m
C1 0 4 1u
.op
.end
