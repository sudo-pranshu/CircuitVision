* drafter_12/C133_D2_P1.jpg
* ground: implicit: most connected net
R1 0 7 1k
C1 4 0 1u
L1 2 7 1m
* WARNING V1: found 3 terminals [0, 1, 3], skipped
.op
.end
