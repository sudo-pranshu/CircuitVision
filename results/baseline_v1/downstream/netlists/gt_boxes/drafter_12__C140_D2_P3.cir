* drafter_12/C140_D2_P3.jpg
* ground: none
.op
.end
