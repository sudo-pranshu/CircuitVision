* drafter_12/C136_D2_P2.jpg
* ground: implicit: most connected net
R1 3 0 1k
* WARNING V1: found 3 terminals [2, 4, 0], skipped
.op
.end
