* drafter_12/C140_D1_P4.jpg
* ground: none
.op
.end
