* drafter_12/C133_D1_P2.jpg
* ground: implicit: first source, second terminal
R1 4 3 1k
V1 4 0 DC 5
L1 1 3 1m
* WARNING C1: found 1 terminals [4], skipped
.op
.end
