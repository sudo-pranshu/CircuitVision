* drafter_12/C138_D2_P4.jpg
* ground: implicit: first source, second terminal
R1 3 4 1k
L1 2 3 1m
C1 3 4 1u
D1 0 2 DMOD
V1 4 0 DC 5
.model DMOD D
.op
.end
