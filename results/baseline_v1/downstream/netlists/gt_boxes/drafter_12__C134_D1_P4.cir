* drafter_12/C134_D1_P4.jpg
* ground: implicit: most connected net
R1 1 0 1k
L1 4 3 1m
C1 0 3 1u
.op
.end
