* drafter_12/C137_D2_P3.jpg
* ground: implicit: first source, second terminal
R1 3 0 2
C1 2 3 1u
R2 6 0 1k
R3 1 2 1k
V1 1 0 DC 5
.op
.end
