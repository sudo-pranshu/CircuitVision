* drafter_12/C139_D2_P3.jpg
* ground: none
.op
.end
