* drafter_12/C135_D1_P3.jpg
* ground: implicit: most connected net
D1 0 4 DMOD
D2 4 0 DMOD
D3 2 0 DMOD
D4 0 2 DMOD
.model DMOD D
.op
.end
