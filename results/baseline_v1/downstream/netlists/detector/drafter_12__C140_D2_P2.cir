* drafter_12/C140_D2_P2.jpg
* ground: none
.op
.end
