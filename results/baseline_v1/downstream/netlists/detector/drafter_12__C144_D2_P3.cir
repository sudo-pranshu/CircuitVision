* drafter_12/C144_D2_P3.jpg
* ground: none
.op
.end
