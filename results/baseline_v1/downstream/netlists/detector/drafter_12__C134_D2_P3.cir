* drafter_12/C134_D2_P3.jpg
* ground: implicit: most connected net
R1 2 0 1k
C1 0 5 1u
L1 2 5 1m
* WARNING C2: found 1 terminals [0], skipped
.op
.end
