* drafter_12/C140_D1_P2.jpg
* ground: none
.op
.end
