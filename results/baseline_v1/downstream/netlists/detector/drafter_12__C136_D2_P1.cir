* drafter_12/C136_D2_P1.jpg
* ground: implicit: most connected net
R1 2 0 1k
* WARNING C1: found 3 terminals [1, 0, 4], skipped
.op
.end
