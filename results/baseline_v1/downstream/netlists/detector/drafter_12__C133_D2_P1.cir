* drafter_12/C133_D2_P1.jpg
* ground: implicit: first source, second terminal
C1 4 5 1u
V1 5 0 DC 5
R1 5 6 1k
L1 3 6 1m
C3 0 5 1u
* WARNING C2: found 1 terminals [4], skipped
.op
.end
