* drafter_12/C140_D2_P1.jpg
* ground: none
.op
.end
