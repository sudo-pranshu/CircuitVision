* drafter_12/C141_D2_P4.jpg
* ground: none
.op
.end
