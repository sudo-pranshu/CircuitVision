* drafter_12/C139_D2_P4.jpg
* ground: none
.op
.end
