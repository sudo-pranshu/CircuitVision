* drafter_12/C142_D2_P2.jpg
* ground: none
.op
.end
