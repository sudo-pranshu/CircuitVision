* drafter_12/C138_D2_P1.jpg
* ground: implicit: first source, second terminal
V1 4 0 DC 5
D1 0 2 DMOD
L1 2 3 8
R1 3 4 1k
C1 3 4 1u
C2 3 4 1u
.model DMOD D
.op
.end
