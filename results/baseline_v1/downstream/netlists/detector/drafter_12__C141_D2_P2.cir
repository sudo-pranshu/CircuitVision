* drafter_12/C141_D2_P2.jpg
* ground: none
.op
.end
