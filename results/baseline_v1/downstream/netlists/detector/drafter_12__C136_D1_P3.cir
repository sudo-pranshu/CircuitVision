* drafter_12/C136_D1_P3.jpg
* ground: implicit: first source, second terminal
V1 3 0 DC 5
R1 1 3 1k
.op
.end
