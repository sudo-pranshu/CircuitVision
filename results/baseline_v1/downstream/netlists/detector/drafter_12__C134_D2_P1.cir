* drafter_12/C134_D2_P1.jpg
* ground: implicit: most connected net
L1 0 5 1m
R1 0 2 1k
C1 2 5 1u
.op
.end
