* drafter_12/C134_D1_P2.jpg
* ground: implicit: most connected net
C1 4 0 1u
L1 2 0 1m
R1 2 3 1k
.op
.end
