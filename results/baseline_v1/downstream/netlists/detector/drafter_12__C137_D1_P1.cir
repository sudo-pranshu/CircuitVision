* drafter_12/C137_D1_P1.jpg
* ground: implicit: first source, second terminal
R1 2 0 1k
R2 1 3 1k
C1 3 2 1u
R3 2 0 1k
C2 1 0 1u
V1 1 0 DC 5
.op
.end
