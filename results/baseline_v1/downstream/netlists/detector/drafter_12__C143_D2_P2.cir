* drafter_12/C143_D2_P2.jpg
* ground: none
.op
.end
