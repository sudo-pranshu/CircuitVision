* drafter_12/C136_D2_P4.jpg
* ground: none
* WARNING R1: found 0 terminals [], skipped
* WARNING C1: found 0 terminals [], skipped
.op
.end
