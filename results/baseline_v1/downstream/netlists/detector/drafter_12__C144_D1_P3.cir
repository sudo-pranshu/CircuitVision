* drafter_12/C144_D1_P3.jpg
* ground: none
.op
.end
