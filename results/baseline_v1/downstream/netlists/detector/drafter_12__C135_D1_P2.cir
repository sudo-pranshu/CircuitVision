* drafter_12/C135_D1_P2.jpg
* ground: implicit: most connected net
D1 0 1 DMOD
D2 1 0 DMOD
D3 0 2 DMOD
D4 2 0 DMOD
.model DMOD D
.op
.end
