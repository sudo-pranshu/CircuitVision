* drafter_12/C143_D2_P4.jpg
* ground: none
.op
.end
