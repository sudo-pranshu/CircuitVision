* drafter_12/C144_D2_P2.jpg
* ground: implicit: most connected net
* WARNING R1: found 1 terminals [0], skipped
.op
.end
