* drafter_12/C139_D1_P3.jpg
* ground: none
.op
.end
