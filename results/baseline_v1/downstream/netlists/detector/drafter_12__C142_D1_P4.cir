* drafter_12/C142_D1_P4.jpg
* ground: implicit: most connected net
* WARNING R1: found 1 terminals [0], skipped
.op
.end
