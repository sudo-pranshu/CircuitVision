* drafter_12/C133_D2_P4.jpg
* ground: implicit: first source, second terminal
V1 7 0 DC 5
R1 7 6 1k
C1 5 7 1u
L1 3 6 1m
C2 5 7 6
.op
.end
