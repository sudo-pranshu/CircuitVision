* drafter_12/C139_D2_P1.jpg
* ground: none
.op
.end
