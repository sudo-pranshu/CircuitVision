* drafter_12/C144_D1_P2.jpg
* ground: implicit: most connected net
R1 0 3 1k
.op
.end
