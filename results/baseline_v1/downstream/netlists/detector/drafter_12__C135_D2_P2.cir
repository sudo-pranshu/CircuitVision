* drafter_12/C135_D2_P2.jpg
* ground: implicit: most connected net
D1 0 5 DMOD
D2 0 5 DMOD
D3 5 0 DMOD
D4 5 0 DMOD
.model DMOD D
.op
.end
