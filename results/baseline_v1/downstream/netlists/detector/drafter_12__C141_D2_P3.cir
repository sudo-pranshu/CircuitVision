* drafter_12/C141_D2_P3.jpg
* ground: none
.op
.end
