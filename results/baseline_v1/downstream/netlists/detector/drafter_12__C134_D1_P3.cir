* drafter_12/C134_D1_P3.jpg
* ground: implicit: first source, second terminal
C1 3 4 1u
L1 5 4 1m
R1 0 2 1k
V1 5 0 DC 5
.op
.end
