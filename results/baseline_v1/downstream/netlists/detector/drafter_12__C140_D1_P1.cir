* drafter_12/C140_D1_P1.jpg
* ground: none
.op
.end
