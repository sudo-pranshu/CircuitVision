* drafter_12/C137_D2_P4.jpg
* ground: implicit: first source, second terminal
R1 1 0 1k
R2 1 0 1k
R3 2 3 1k
C1 3 1 1u
C2 2 0 1u
V1 2 0 DC 5
.op
.end
