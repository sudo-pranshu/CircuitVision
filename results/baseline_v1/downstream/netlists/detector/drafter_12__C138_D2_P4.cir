* drafter_12/C138_D2_P4.jpg
* ground: implicit: first source, second terminal
V1 4 0 DC 5
D1 0 2 DMOD
C1 3 4 1u
L1 2 3 5
R1 3 4 1k
.model DMOD D
.op
.end
