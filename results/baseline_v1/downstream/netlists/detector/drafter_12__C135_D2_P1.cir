* drafter_12/C135_D2_P1.jpg
* ground: implicit: most connected net
D1 0 1 DMOD
D2 0 2 DMOD
D3 1 0 DMOD
D4 2 0 DMOD
.model DMOD D
.op
.end
