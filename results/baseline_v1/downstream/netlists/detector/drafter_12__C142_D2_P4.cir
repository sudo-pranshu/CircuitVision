* drafter_12/C142_D2_P4.jpg
* ground: none
.op
.end
