* drafter_12/C135_D1_P3.jpg
* ground: implicit: most connected net
D1 0 3 DMOD
D2 0 2 DMOD
D3 3 0 DMOD
D4 2 0 DMOD
.model DMOD D
.op
.end
