* drafter_12/C136_D2_P2.jpg
* ground: implicit: most connected net
R1 2 0 1k
* WARNING C1: found 3 terminals [4, 0, 5], skipped
.op
.end
