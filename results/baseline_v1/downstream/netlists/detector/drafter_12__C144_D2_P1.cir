* drafter_12/C144_D2_P1.jpg
* ground: none
* WARNING R1: found 0 terminals [], skipped
.op
.end
