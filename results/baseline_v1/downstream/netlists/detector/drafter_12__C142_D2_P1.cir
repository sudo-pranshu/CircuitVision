* drafter_12/C142_D2_P1.jpg
* ground: none
.op
.end
