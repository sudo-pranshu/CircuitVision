* drafter_12/C143_D1_P4.jpg
* ground: none
.op
.end
